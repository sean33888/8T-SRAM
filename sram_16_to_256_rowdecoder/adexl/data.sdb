ADE simulation setup
Run mode: Single Run, Sweeps and Corners
Tests:
  FYP_myLib:sram_16_to_256_rowdecoder:1: FYP_myLib/sram_16_to_256_rowdecoder/schematic, simulator spectre
